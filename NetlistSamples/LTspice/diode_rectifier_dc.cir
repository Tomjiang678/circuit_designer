Circuit Module Designer - nominal diode rectifier DC example
* Abstract op-amp is a finite-gain E-source; it is not a vendor op-amp model.
V_INPUT VIN 0 DC 0
R1 VIN SUM 1e+4
R2 SUM RAW 1e+4
E_U1 RAW 0 0 SUM 1e+9
D1 RAW VOUT CMD_DIODE
R_LOAD VOUT 0 1e+6
.MODEL CMD_DIODE D(IS=1e-12 N=1e+0)
.TEMP 2.5e+1
.DC V_INPUT -5e+0 5e+0 1e-1
.PRINT DC V(VOUT)
.END
